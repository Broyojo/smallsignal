Source follower with body effect and capacitances
VDD vdd 0 1.8
VIN in 0 DC 1.4 AC 1
RS in g 5k
M1 vdd g out 0 nchb W=10u L=1u AD=20p AS=20p PD=24u PS=24u
IB out 0 50u
CL out 0 200f
.model nchb NMOS (LEVEL=1 KP=200u VTO=0.5 LAMBDA=0.1 GAMMA=0.4 PHI=0.7 TOX=20n CGSO=3e-10 CGDO=3e-10 CGBO=1e-10 CJ=5e-4 CJSW=3e-10 MJ=0.4 MJSW=0.3 PB=0.85)
.end
