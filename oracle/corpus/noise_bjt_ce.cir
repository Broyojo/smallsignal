BJT CE with emitter degeneration and base flicker noise (KF, AF)
VCC vcc 0 10
VIN in 0 DC 1.0 AC 1
RB in b 1k
Q1 c b e qnf
RE e 0 500
RC vcc c 4k
CL c 0 10p
.model qnf NPN (IS=1e-15 BF=100 VAF=50 KF=1e-16 AF=1)
.end
