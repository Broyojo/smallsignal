NMOS differential pair, two-source differential drive, output at the tail: a1 = a3 = 0 by symmetry
VDD vdd 0 3
VIP inp 0 DC 1.2
VINN inn 0 DC 1.2
M1 o1 inp tail 0 nch W=10u L=1u
M2 o2 inn tail 0 nch W=10u L=1u
ITAIL tail 0 DC 200u
RD1 vdd o1 5k
RD2 vdd o2 5k
CL1 o1 0 1p
CL2 o2 0 1p
.model nch NMOS (LEVEL=1 KP=200u VTO=0.5 LAMBDA=0.1)
.end
