Resistive divider
VIN in 0 DC 1 AC 1
R1 in out 10k
R2 out 0 30k
.end
