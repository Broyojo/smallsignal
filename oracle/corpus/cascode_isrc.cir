NMOS cascode into an ideal current source
VDD vdd 0 3
VIN in 0 DC 0.9123687519 AC 1
VB vb 0 1.5
IB vdd out DC 50u
M2 out vb x 0 nch W=20u L=2u
M1 x in 0 0 nch W=20u L=2u
.model nch NMOS (LEVEL=1 KP=100u VTO=0.6 LAMBDA=0.05 GAMMA=0.4 PHI=0.8)
.end
