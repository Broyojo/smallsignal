NMOS CS, ideal current-source load: HD2 = 3A/(4Vov), HD3 = A^2/(2Vov^2)
VIN in 0 DC 0.9 AC 1
IL 0 out DC 168u
M1 out in 0 0 nch W=10u L=1u
.model nch NMOS (LEVEL=1 KP=200u VTO=0.5 LAMBDA=0.1)
.end
