NMOS differential pair with capacitances, differential drive
VDD vdd 0 1.8
VP inp 0 DC 0.9 AC 1
VN inn 0 DC 0.9 AC 1
R1 vdd o1 10k
R2 vdd o2 10k
M1 o1 inp tail 0 nch W=10u L=1u AD=20p AS=20p PD=24u PS=24u
M2 o2 inn tail 0 nch W=10u L=1u AD=20p AS=20p PD=24u PS=24u
IT tail 0 100u
.model nch NMOS (LEVEL=1 KP=200u VTO=0.5 LAMBDA=0.1 TOX=20n CGSO=3e-10 CGDO=3e-10 CGBO=1e-10 CJ=5e-4 CJSW=3e-10 MJ=0.4 MJSW=0.3 PB=0.85)
.end
