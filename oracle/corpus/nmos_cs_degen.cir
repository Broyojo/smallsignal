NMOS common source with source degeneration
VDD vdd 0 1.8
VIN in 0 DC 1.0 AC 1
RD vdd out 5k
M1 out in s 0 nch W=10u L=1u
RS s 0 1k
CL out 0 1p
.model nch NMOS (LEVEL=1 KP=200u VTO=0.5 LAMBDA=0.1)
.end
