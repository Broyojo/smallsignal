Five-transistor OTA with capacitances
VDD vdd 0 1.8
VCM cm 0 1.0
VIN inp cm DC 0 AC 1
M1 x inp tail 0 nch W=10u L=1u AD=20p AS=20p PD=24u PS=24u
M2 out cm tail 0 nch W=10u L=1u AD=20p AS=20p PD=24u PS=24u
M3 x x vdd vdd pch W=20u L=1u AD=40p AS=40p PD=44u PS=44u
M4 out x vdd vdd pch W=20u L=1u AD=40p AS=40p PD=44u PS=44u
M5 tail vbn 0 0 nch W=10u L=1u AD=20p AS=20p PD=24u PS=24u
VBN vbn 0 0.7
CL out 0 200f
.model nch NMOS (LEVEL=1 KP=200u VTO=0.5 LAMBDA=0.1 TOX=20n CGSO=3e-10 CGDO=3e-10 CGBO=1e-10 CJ=5e-4 CJSW=3e-10 MJ=0.4 MJSW=0.3 PB=0.85)
.model pch PMOS (LEVEL=1 KP=80u VTO=-0.5 LAMBDA=0.1 TOX=20n CGSO=3e-10 CGDO=3e-10 CJ=6e-4 CJSW=2e-10 MJ=0.45 PB=0.8)
.end
