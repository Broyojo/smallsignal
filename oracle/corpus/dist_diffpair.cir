NMOS differential pair, differential output: HD2 = 0 by symmetry, HD3 from the square law
VDD vdd 0 3
VCM cm 0 1.2
VIN inp cm DC 0 AC 1
M1 o1 inp tail 0 nch W=10u L=1u
M2 o2 cm tail 0 nch W=10u L=1u
ITAIL tail 0 DC 200u
RD1 vdd o1 5k
RD2 vdd o2 5k
.model nch NMOS (LEVEL=1 KP=200u VTO=0.5 LAMBDA=0.1)
.end
