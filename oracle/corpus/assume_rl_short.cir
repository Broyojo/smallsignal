Series RLC with the inductor taken as a short
VIN in 0 DC 0 AC 1
R1 in a 10
L1 a out 10u
C1 out 0 1n
RL out 0 100k
.end
