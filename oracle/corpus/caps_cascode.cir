NMOS cascode with capacitances
VDD vdd 0 3
VIN in 0 DC 0.8 AC 1
RS in g 2k
VB2 vb2 0 1.6
RD vdd out 10k
M1 x g 0 0 nch W=10u L=1u AD=20p AS=20p PD=24u PS=24u
M2 out vb2 x 0 nch W=10u L=1u AD=20p AS=20p PD=24u PS=24u
CL out 0 100f
.model nch NMOS (LEVEL=1 KP=200u VTO=0.5 LAMBDA=0.1 TOX=20n CGSO=3e-10 CGDO=3e-10 CGBO=1e-10 CJ=5e-4 CJSW=3e-10 MJ=0.4 MJSW=0.3 PB=0.85)
.end
