Diode flicker at zero bias with AF=0: ngspice floors |Id| at 1e-38, so KF/f remains
VIN a 0 DC 0 AC 1
R1 a out 1k
R2 out 0 1k
D1 out 0 dm
.model dm D (IS=1e-14 KF=1e-12 AF=0)
.end
