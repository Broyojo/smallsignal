NMOS CS, resistor load with load capacitor (distortion above the pole)
VDD vdd 0 5
VIN in 0 DC 0.9 AC 1
RD vdd out 5k
CL out 0 10p
M1 out in 0 0 nch W=10u L=1u
.model nch NMOS (LEVEL=1 KP=200u VTO=0.5 LAMBDA=0.1)
.end
