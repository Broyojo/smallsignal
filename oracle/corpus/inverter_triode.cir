CMOS inverter, M1 in triode
VDD vdd 0 1.8
VIN in 0 DC 1.1 AC 1
M1 out in 0 0 nch W=10u L=1u
M2 out in vdd vdd pch W=20u L=1u
.model nch NMOS (LEVEL=1 KP=200u VTO=0.5 LAMBDA=0.1)
.model pch PMOS (LEVEL=1 KP=100u VTO=-0.5 LAMBDA=0.1)
.end
