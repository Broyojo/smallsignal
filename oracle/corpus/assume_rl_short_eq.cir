Series RC, ngspice equivalent of assume_rl_short (L1 a 0 V source)
VIN in 0 DC 0 AC 1
R1 in a 10
VL1 a out DC 0
C1 out 0 1n
RL out 0 100k
.end
