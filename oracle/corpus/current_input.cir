Current-driven resistor network (transimpedance)
IIN 0 in DC 0 AC 1
R1 in 0 1k
R2 in out 1k
R3 out 0 1k
C1 out 0 1n
.end
