Inverting amplifier with a VCVS op-amp
VIN in 0 DC 0 AC 1
R1 in n 1k
R2 n out 10k
E1 out 0 0 n 100k
RL out 0 2k
.end
