RC lowpass, ngspice equivalent of assume_rc_open (C2 removed)
VIN in 0 DC 0 AC 1
R1 in out 1k
C1 out 0 1n
.end
