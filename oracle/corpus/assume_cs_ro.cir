CS stage, r_o ignored
VDD vdd 0 1.8
VIN in 0 DC 0.8 AC 1
RD vdd out 10k
M1 out in 0 0 nch W=10u L=1u
CL out 0 1p
.model nch NMOS (LEVEL=1 KP=200u VTO=0.5 LAMBDA=0.1)
.end
