BJT CE with emitter degeneration and Early effect
VCC vcc 0 10
VIN in 0 DC 1.0 AC 1
Q1 c in e qn
RE e 0 500
RC vcc c 4k
.model qn NPN (IS=1e-15 BF=100 VAF=50)
.end
