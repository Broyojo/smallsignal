Diode with junction and diffusion capacitance
VIN in 0 DC 0.7 AC 1
RS in a 1k
D1 a 0 dcap
R2 a 0 10k
.model dcap D (IS=1e-14 CJO=2p VJ=0.7 M=0.4 TT=2n FC=0.4)
.end
