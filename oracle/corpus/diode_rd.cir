Diode small-signal resistance
VIN in 0 DC 1 AC 1
R1 in a 1k
D1 a 0 dd
.model dd D (IS=1e-14 N=1.5)
.end
