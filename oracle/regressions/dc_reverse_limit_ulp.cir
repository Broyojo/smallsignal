random wild mos circuit
V1 vdd 0 DC 2.85
V2 in 0 DC 0.236 AC 1
R1 n1 vdd 3.983e+05
R2 n2 in 828.1
M6 vdd in 0 vdd pch W=62.12u L=1u
.model pch PMOS (LEVEL=1 KP=0.0004965 VTO=-0.7163 LAMBDA=0.08075 GAMMA=0.459 PHI=0.7)
.end
