random wild mos circuit
V1 vdd 0 DC 2.59
V2 in 0 DC 0.631 AC 1
R1 n8 vdd 3021
R2 n5 vdd 431.5
R3 n2 m2 7.744e+05
R4 n6 n2 1.591e+05
R6 n1 m1 2214
M5 n4 n6 0 0 nch W=6.044u L=0.5u
L1 n1 n4 3.605e-09
V3 m1 n5 DC 0
F1 0 n6 V3 -0.1733
V4 m2 n5 DC 0
.model nch NMOS (LEVEL=1 KP=9.003e-05 VTO=0.7207 LAMBDA=0.08072 GAMMA=0 PHI=0.7)
.end
