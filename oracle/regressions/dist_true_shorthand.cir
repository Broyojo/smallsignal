NMOS CS, resistor load, "distortion": true (the default settings), bias written 900m
VDD vdd 0 5
VIN in 0 DC 900m AC 1
RD vdd out 5k
M1 out in 0 0 nch W=10u L=1u
.model nch NMOS (LEVEL=1 KP=200u VTO=0.5 LAMBDA=0.1)
.end
