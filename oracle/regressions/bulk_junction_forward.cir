random wild mos circuit
V1 vdd 0 DC 2.72
V2 in 0 DC 0.414 AC 1
R1 n2 vdd 2724
M5 0 n2 n2 n2 nch W=4.595u L=5u
.model nch NMOS (LEVEL=1 KP=0.0003131 VTO=0.747 LAMBDA=0.006308 GAMMA=0 PHI=0.7)
.end
